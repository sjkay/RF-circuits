# Ansys Electronics Desktop project, version 2018.0
materials:
  vacuum: permittivity=1
  FR4_epoxy: permittivity=4.4 dielectric_loss_tangent=0.02
  copper: permeability=0.999991 conductivity=58000000

design HFSSDesign1 (HFSS, DrivenModal, model units mm)
variables:
  a = 50mm
  b = 50mm
  bigr = 6.35mm
geometry:
  Box1 [FR4_epoxy] = box(corner=(-a/2, -b/2, 0mm), size=(a, b, 1mm))
  Circle1 = circle(normal=Z, centre=(0mm, 0mm, 1mm), radius=bigr)
  Circle2 = circle(normal=Z, centre=(0mm, 0mm, 1mm), radius=bigr-1mm)
  Circle1.subtract(Circle2)
  Rectangle1 = rectangle(corner=(0mm-1mm, -b/2, 1mm), x_size=2mm, y_size=19.5mm)
  Rectangle2 = rectangle(corner=(0mm-1mm, bigr, 1mm), x_size=2mm, y_size=19/sqrt(2) mm)
  Rectangle2.rotate(axis=Z, angle=45deg)
  Rectangle3 = rectangle(corner=(0mm-1mm, bigr, 1mm), x_size=2mm, y_size=19/sqrt(2) mm)
  Rectangle3.rotate(axis=Z, angle=-45deg)
  Rectangle4 = rectangle(corner=(-1mm, 2mm, 1mm), x_size=2mm, y_size=12mm)
  Circle1.subtract(Rectangle4)
  Rectangle5 = rectangle(corner=(-1mm, 8.9442719mm, 1mm), x_size=2mm, y_size=1.0056025mm)
  Rectangle2.move(5.363961mm, 2.1716998mm, 0mm)
  Rectangle3.move(-5.363961mm, 2.1716998mm, 0mm)
  Rectangle6 = rectangle(corner=(10.5mm, 14.949874mm, 1mm), x_size=14.5mm, y_size=-2mm)
  Rectangle7 = rectangle(corner=(-10.5mm, 14.949874mm, 1mm), x_size=-14.5mm, y_size=-2mm)
  Box2 [vacuum] = box(corner=(-a/2, -b/2, -4mm), size=(a, b, 16mm))
  Rectangle8 = rectangle(corner=(-7mm, -a/2, 0mm), z_size=8mm, x_size=14mm)
  Rectangle9 = rectangle(corner=(a/2, 20mm, 0mm), y_size=-12mm, z_size=6mm)
  Rectangle10 = rectangle(corner=(-a/2, 20mm, 0mm), y_size=-12mm, z_size=6mm)
  Rectangle2.move(-1.4142136mm, -0.53566081mm, 0mm)
  Rectangle3.move(1.4142136mm, -0.53566081mm, 0mm)
  Rectangle5.move(0mm, -1.9498744mm, 0mm)
  Rectangle5.move(0mm, 0mm, 0mm)
  Rectangle5.move(0mm, -2.5916731mm, 0mm)
  Rectangle3.move(1.767767mm, -0.82390613mm, 0mm)
  Rectangle2.move(-1mm, -0.59167309mm, 1mm)
  Rectangle2.move(-0.76776695mm, -0.23223305mm, -1mm)
  Rectangle7.move(0mm, 0mm, 0mm)
  Rectangle5.move(-1mm, 1.5916731mm, 0mm)
  Rectangle5.move(1mm, -2.1010205mm, 0mm)
  Rectangle5.move(0.35355339mm, -0.15579404mm, 0mm)
  Rectangle5.move(-0.35355339mm, 0.15579404mm, 0mm)
  Rectangle3.move(0.35355339mm, -0.15579404mm, 0mm)
  Rectangle2.move(-0.35355339mm, -0.054773523mm, 0mm)
  Rectangle6.move(0.5mm, -0.050894885mm, 0mm)
  Rectangle7.move(-0.5mm, 0.050125629mm, 0mm)
  Rectangle3.move(0mm, 14mm, 0mm)
  Rectangle5.move(0mm, 0.30582599mm, 0mm)
  Rectangle3.move(-0.21213203mm, -13.906306mm, 0mm)
  Rectangle2.move(0.21213203mm, -0.0073265625mm, 0mm)
  Rectangle7.move(0.5mm, -0.29519453mm, 0mm)
  Rectangle6.move(0mm, 0mm, 0mm)
  Rectangle6.move(-0.5mm, -0.19417401mm, 0mm)
  Rectangle5.move(0mm, 0.50833727mm, 0mm)
  Rectangle3.move(-0.35355339mm, 0.15478388mm, 0mm)
  Rectangle2.move(0.35355339mm, 0.15478388mm, 0mm)
  [Rectangle7, Rectangle6].move(0mm, 0.50833727mm, 0mm)
  Rectangle5.move(0mm, 0mm, 0mm)
  Rectangle5.move(-1mm, 7.203126mm, 1mm)
  Rectangle5.move(1mm, -7.1016321mm, -1mm)
  Rectangle3.move(-0.070710678mm, 0.030783283mm, 0mm)
  Rectangle2.move(0.070710678mm, 0.030783283mm, 0mm)
  Rectangle7.move(0mm, -3mm, 0mm)
  Rectangle7.move(0mm, 3.101494mm, 0mm)
  Rectangle6.move(0mm, -2mm, 0mm)
  Rectangle6.move(1.7763568e-15mm, 2.101494mm, 0mm)
  Rectangle3.move(0mm, 8mm, 0mm)
  Rectangle3.move(0mm, 0.20283785mm, 0mm)
  Rectangle5.move(0mm, 0.50280123mm, 0mm)
  Rectangle5.move(0mm, -0.29996338mm, 0mm)
  Rectangle3.move(-0.14142136mm, -8.1414214mm, 0mm)
  Rectangle2.move(-2mm, 10mm, 0mm)
  Rectangle2.move(2.1414214mm, -9.9385835mm, 0mm)
  Rectangle7.move(0mm, -6mm, 0mm)
  Rectangle7.move(0mm, 6.2028378mm, 0mm)
  Rectangle6.move(-2mm, -6mm, 0mm)
  Rectangle6.move(2mm, 6.2028378mm, 0mm)
  Rectangle5.move(1mm, 5.7292345mm, 1mm)
  Rectangle5.move(-1mm, -5.4759435mm, -1mm)
  Rectangle3.move(-2mm, 8mm, 0mm)
  Rectangle3.move(1.8232233mm, -7.9234857mm, 0mm)
  Rectangle2.move(2mm, 8mm, 0mm)
  Rectangle2.move(-1.8232233mm, -7.9234857mm, 0mm)
  Rectangle7.move(2mm, -8mm, 0mm)
  Rectangle7.move(-2mm, 8.253291mm, 0mm)
  Rectangle6.move(-1.75mm, -6.5174746mm, 1mm)
  Rectangle6.move(1.75mm, 6.7707655mm, -1mm)
  Circle1.unite(Rectangle1, Rectangle3, Rectangle6, Rectangle2, Rectangle7)
boundaries and excitations:
  FiniteCond2: Finite Conductivity Faces=Box1.face(-z) UseMaterial Material=copper IsInternal
  LumpRLC1: Lumped RLC Objects=Rectangle5 CurrentLine{middle of Rectangle5.edge(x at corner) -> middle of Rectangle5.edge(x opposite corner)} Resistance=100ohm
  Rad1: Radiation Objects=Box2
  FiniteCond3: Finite Conductivity Objects=Circle1 UseMaterial Material=copper IsInternal
  1: Wave Port Objects=Rectangle8 NumModes=1 Modes{Mode1{CharImp=Zpi RenormImp=50ohm}}
  2: Wave Port Objects=Rectangle10 NumModes=1 Modes{Mode1{CharImp=Zpi RenormImp=50ohm}}
  3: Wave Port Objects=Rectangle9 NumModes=1 Modes{Mode1{CharImp=Zpi RenormImp=50ohm}}
setups:
  Setup1: HfssDriven Frequency=3GHz MaxDeltaS=0.02 MaximumPasses=6 MinimumPasses=1 MinimumConvergedPasses=1 PercentRefinement=30 BasisOrder=1 PortAccuracy=2
    sweep Sweep: 0.1GHz to 5GHz, 451 points; Type=Fast SaveFields
source amplitudes:
  1:1: 1W 0deg
  2:1, 3:1: 0W 0deg
reports:
  S Parameter Plot 1: dB(S(1,1)), dB(S(2,1)), dB(S(3,2)) vs Freq on Setup1 : Sweep; markers m1 at 3.0182222GHz
